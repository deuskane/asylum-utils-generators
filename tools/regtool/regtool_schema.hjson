{
  "type"                  : "object"
  "required"              : ["name","registers"]
  "additionalProperties"  : false
  "properties"            : {
    "name"                : {
      "type"              : "string",
      "description"       : "Module Name"
    }              
    "desc"                : {
      "type"              : "string",
      "description"       : "Module Description"
      "default"           : ""
    }              
    "width"               : {
      "type"              : "integer",
      "description"       : "Data Bus Width"
      "default"           : 32
    }              
    "interface"           : {
      "type"              : "string",
      "description"       : "Interface Type (mem, or a bus through the bridge <bus>2mem ; reg : alias of mem)"
      "default"           : "mem"
      "enum"              : ["mem","reg","pbi","sbi","apb","axi4lite"]
    }# end of properties "top"

   "parameters"           : {

      "type"              : "array",
      "items"             : {
        "type"                  : "object",
        "required"              : ["name","type"]
        "additionalProperties"  : false
        "properties"            : {
          "name"                : {
            "type"              : "string",
            "description"       : "Parameter Name"
          }
          "desc"                : {
            "type"              : "string",
            "description"       : "Parameter Description"
	        "default"           : ""
          }              
          "type"                : {
            "type"              : "string",
            "description"       : "Parameter Type"
	        }
        }# end of properties "parameters"
      }#end of items "parameters"
    }#end of "parameters"

   "registers"           : {

      "type"              : "array",
      "items"             : {
        "type"                  : "object",
        "required"              : ["name","fields"]
        "additionalProperties"  : false
        "properties"            : {
          "name"                : {
            "type"              : "string",
            "description"       : "Register Name"
          }
          "desc"                : {
            "type"              : "string",
            "description"       : "Register Description"
            "default"           : ""
          }              
          "enable"              : {
            "type"              : "string",
            "description"       : "Register Enable"
            "default"           : "True"
          }              
          "address"             : {
            "type"              : "string",
            "description"       : "Register Address"
          }              
          "alias_write"         : {
            "type"              : "string",
            "description"       : "Register Write Alias"
          }              
          "hwtype"              : {
            "type"              : "string",
            "description"       : "Register Hardware Type",
            "enum"              : ["reg","ext","fifo"],
            "default"           : "reg"
          }              
          "hwaccess"            : {
            "type"              : "string",
            "description"       : "Register Hardware Access",
            "enum"              : ["rw","wo","ro","none"],
            "default"           : "rw"
          }              
          "swaccess"            : {
            "type"              : "string",
            "description"       : "Register Software Access",
            "enum"              : ["rw","wo","ro","rw1c", "rw0c", "rw1s", "rw0s","rsw1c","rcw1s", "rsw0c"],
            "default"           : "rw"
          }              
          # Wait states (hwtype reg only) : 0 when absent (no default here :
          # the key is not added to the registers without wait states)
          "rd_wait_state"       : {
            "type"              : ["integer","string"],
            "description"       : "Register Software Read Wait States (integer >= 0 or expression, default 0)"
          }              
          "wr_wait_state"       : {
            "type"              : ["integer","string"],
            "description"       : "Register Software Write Wait States (integer >= 0 or expression, default 0)"
          }              

          "fields"           : {
      
            "type"              : "array",
            "items"             : {
              "type"                  : "object",
              "required"              : ["name","bits"]
              "additionalProperties"  : false
              "properties"            : {
                "name"                : {
                  "type"              : "string",
                  "description"       : "Field Name"
                }
                "desc"                : {
                  "type"              : "string",
                  "description"       : "Field Description"
                  "default"           : ""
                }              
                "init"                : {
                  "type"              : "string",
                  "description"       : "Field Initialization Value",
                  "default"           : "0"
                }
                "expr"                : {
                  "type"              : "string",
                  "description"       : "Field Initialization Expression",
                  "default"           : ""
                }
                "bits"                : {
                  "type"              : "string",
                  "description"       : "Field Range in register",
                }

                "enum"                : {
                  "type"              : "array",
                  "items"             : {
                    "type"                  : "object",
                    "required"              : ["name","value"]
                    "additionalProperties"  : false
                    "properties"            : {
                      "name"                : {
                        "type"              : "string",
                        "description"       : "Enum Name"
                      }
                      "desc"                : {
                        "type"              : "string",
                        "description"       : "Enum Description"
                        "default"           : ""
                      }
                      "value"               : {
                        "type"              : "string",
                        "description"       : "Enum Value"
                      }
                    }# end of properties "enum"
                  }#end of items "enum"
                }#end of "enum"
              }# end of properties "fields"
            }#end of items "fields"
          }#end of "fields"

          "params"           : {
            "type"                  : "object",
            "additionalProperties"  : true
          }#end of "params"

        }# end of properties "registers"
      }#end of items "registers"
    }#end of "registers"
  }
}
