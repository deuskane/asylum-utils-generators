{
    name      : "example1",
    width     : 32,
    async_read: true,
    registers : [
        {
            name       : "reg1",
            address    : "00",
            desc       : "Register 1",
            hwaccess   : "rw",
            swaccess   : "rw",
            fields: [
                {
                    name: "field1",
                    bits: "0",
                    init: "d0",
                    desc: "Field 1"
                },
                {
                    name: "field2",
                    bits: "1",
                    init: "b1",
                    desc: "Field 2"
                }
            ]
        },
        {
            name       : "reg2",
            address    : "04",
            desc       : "Register 2",
            hwaccess   : "ro",
            swaccess   : "ro",
            fields: [
                {
                    name: "field1",
                    bits: "7:0",
                    init: "x00",
                    desc: "Field 1"
                },
                {
                    name: "field2",
                    bits: "15:8",
                    init: "xFF",
                    desc: "Field 2"
                }
            ]
        }
    ]
}
