{
  name: example2
  desc: test
  width: 32
  registers:
  [
    {
      name: regA
      address: "0"
      desc: A
      hwaccess: ro
      swaccess: rw
      fields:
      [
        {
          name: a
          bits: 7:0
          init: "0"
          desc: a
        }
        {
          name: b
          bits: 15:8
          init: "0"
          desc: b
        }
      ]
    }
  ]
}